// Copyright 2020 The SkyWater PDK Authors
//
// Licensed under the Apache License, Version 2.0 (the "License");
// you may not use this file except in compliance with the License.
// You may obtain a copy of the License at
//
//     https://www.apache.org/licenses/LICENSE-2.0
//
// Unless required by applicable law or agreed to in writing, software
// distributed under the License is distributed on an "AS IS" BASIS,
// WITHOUT WARRANTIES OR CONDITIONS OF ANY KIND, either express or implied.
// See the License for the specific language governing permissions and
// limitations under the License.
//
// SPDX-License-Identifier: Apache-2.0

`define TGROWTH_ABSTOL 1e-6*1e8

`include "constants.vams"
`include "disciplines.vams"

// Based on https://github.com/google/skywater-pdk-libs-sky130_fd_pr_reram/issues/10
// temperature discipline
nature TemperatureGrowth;
    units = "K/s";
    access = FilGrowth;
    abstol = 1e-6*1e8;
endnature

discipline filament_thermal
    potential Temperature;
    flow TemperatureGrowth;
enddiscipline

// thickness discipline
nature FilamentGrowth;
    units = "m/s";
    access = dL;
    idt_nature = Length;
    abstol = 1e-6 * 500;
endnature

nature Length;
    units = "m";
    access = L;
    ddt_nature = FilamentGrowth;
    abstol = 1e-6 * 1e-9;
endnature

discipline filament_thickness
    potential Length;
    flow FilamentGrowth;
enddiscipline

module reram_cell_model(TE, BE, thickness, temperature_out);
    inout TE; // top electrode
    inout BE; // bottom electrode
    inout thickness; // make filament thickness accessible
    electrical TE, BE, thickness, temperature_out;

    // ==================================================
    // input parameters
    // --------------------------------------------------
    // physical area and thickness
    parameter real area_ox             = 0.1024e-12 from (0:inf);                         // area of TE/BE overlap [meters^2]
    parameter real Tox                 = 5.0e-9     from (0:inf);                         // thickness of oxide between TE and BE [meters]
    parameter real Tfilament_max       = 4.9e-9     from (0:inf);                         // maximum thickness of conductive filament (for minimum resistance) [meters]
    parameter real Tfilament_min       = 3.3e-9     from (0:inf);                         // minimum thickness of conductive filament (for maximum resistance) [meters]
    parameter real Tfilament_0         = 3.3e-9     from [Tfilament_min:Tfilament_max];   // initial thickness of conductive filament (at t=0 for transient simulation) [meters]
    // activation energy
    parameter real Eact_generation     = 1.501      from (0:inf);                         // activation energy for vacancy generation [eV]
    parameter real Eact_recombination  = 1.500      from (0:inf);                         // activation energy for vacancy recombination [eV]
    // calibration parameters: I-V
    parameter real I_k1                = 6.140e-5   from (0:inf);                         // current calibration parameter [Amps]
    parameter real Tfilament_ref       = 4.7249e-9  from (0:inf);                         // filament thickness calibration parameter [meters]
    parameter real V_ref               = 0.430      from (0:inf);                         // voltage calibration parameter [Volts]
    // calibration parameters: filament growth
    parameter real velocity_k1         = 150        from (0:inf);                         // velocity calibration parameter [meters/second]
    parameter real gamma_k0            = 16.5       from (0:inf);                         // enhancement factor calibration parameter [unitless]
    parameter real gamma_k1            = -1.25      from (-inf:inf);                      // enhancement factor calibration parameter [unitless]
    // calibration parameters: temperature
    parameter real Temperature_0       = 300        from (0:inf);                         // intial temperature [degrees Kelvin]
    parameter real C_thermal           = 3.1825e-16 from (0:inf);                         // effective thermal capacitance [Joules/Kelvin]
    parameter real tau_thermal         = 0.23e-9    from (0:inf);                         // effective thermal time constant [seconds]
    // simulation control
    parameter real t_step              = 1.0e-9     from (0:inf);                         // maximum time step [seconds]
    // scale filament thickness to be more comparable to regular voltage range
    parameter real thickness_scale_factor = 1e7;
    parameter real temperature_scale_factor = 1e-4;
    parameter real max_dthickness = 10;
    // ==================================================

    // internal parameters
    real a0 = 0.25e-9;           // atomic distance [m]

    filament_thickness Tfilament_current = Tfilament_0;   // current filament thickness [m]
    real Tfilament_dTdt;         // current filament thickness, derivative w.r.t. time [m/s]

    real gamma;                  // local enhancement factor
    filament_thermal Temperature_current = Temperature_0;    // current temperature
    real temperature_dTdt; // temperature growth
    real kT_over_q;              // e.g., 0.0259 at 300 degrees K [eV]

    // local functions
    analog function brick_wall_window;
        input x_in, xmin, xmax, dx_dt;
        real x_in, xmin, xmax, dx_dt;
        begin
            if ( (x_in <= xmin) && (dx_dt < 0) ) begin
                brick_wall_window = 0;
            end else if ( (x_in >= xmax) && (dx_dt > 0) ) begin
                brick_wall_window = 0;
            end else begin
                brick_wall_window = 1;
            end
        end
    endfunction

    // core equations
    analog begin
        // thickness
        gamma = gamma_k0 + gamma_k1 * pow((Tox - L(Tfilament_current))/1.0e-9, 3);
	    kT_over_q = (`P_K * Temp(Temperature_current)) / `P_Q;
        Tfilament_dTdt = velocity_k1 * (exp(-Eact_generation    / kT_over_q) * exp( gamma * a0/Tox * V(TE,BE) / kT_over_q) -
                                        exp(-Eact_recombination / kT_over_q) * exp(-gamma * a0/Tox * V(TE,BE) / kT_over_q));

        if (max_dthickness > 0) begin
            Tfilament_dTdt = max_dthickness*tanh(Tfilament_dTdt/max_dthickness);
        end;
        // Tfilament_dTdt = Tfilament_dTdt * tukey_window(L(Tfilament_current), Tfilament_min, Tfilament_max);
        Tfilament_dTdt = Tfilament_dTdt * brick_wall_window(L(Tfilament_current), Tfilament_min, Tfilament_max, Tfilament_dTdt);

        dL(Tfilament_current) <+ ddt(L(Tfilament_current)) - Tfilament_dTdt;
        // temperature
        temperature_dTdt = (abs(V(TE,BE)*I(TE,BE)) / C_thermal +
                            (Temperature_0 - Temp(Temperature_current)) / tau_thermal);
        FilGrowth(Temperature_current) <+ ddt(Temp(Temperature_current)) - temperature_dTdt;

        // resistance calculation + external probes
        I(TE,BE) <+ I_k1 * exp(-(Tox - L(Tfilament_current))/(Tox - Tfilament_ref)) * sinh( V(TE,BE)/V_ref );
        V(thickness) <+ L(Tfilament_current) * thickness_scale_factor;
        V(temperature_out) <+ Temp(Temperature_current) * temperature_scale_factor;
    end
endmodule
